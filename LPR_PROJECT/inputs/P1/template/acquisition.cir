P1 integrated acquisition nominal_healthy
* NEW simulation integration case; frozen P3 remains unchanged.
* P2-derived model parameters are upstream/offline only.
.param RU=9999.99999999992 RP=100000 CDL=0.0001 RCOUNTER=9999.99999999995 RF=1000000 GAIN=1 OFFSET=0 NOISE=0 REVERSEGAIN=1 UNSTABLE=0
.include p1_opamp.lib
V_req req 0 PWL(0 -0.022 2.00004 -0.022 2.00005 0.022 4.00004 0.022 4.00005 0 66.00004 0 66.00005 -0.005 81.00004 -0.005 81.00005 -0.0025 96.00004 -0.0025 96.00005 0 111.00004 0 111.00005 0.0025 126.00004 0.0025 126.00005 0.005 141.00004 0.005 141.00005 0 142.00004 0 142.00005 -0.01 157.00004 -0.01 157.00005 -0.005 172.00004 -0.005 172.00005 0 187.00004 0 187.00005 0.005 202.00004 0.005 202.00005 0.01 217.00004 0.01 217.00005 0 218.00004 0 218.00005 -0.005 233.00004 -0.005 233.00005 -0.0025 248.00004 -0.0025 248.00005 0 263.00004 0 263.00005 0.0025 278.00004 0.0025 278.00005 0.005 293.00004 0.005 293.00005 0 294.00004 0 294.00005 0.005 309.00004 0.005 309.00005 0.0025 324.00004 0.0025 324.00005 0 339.00004 0 339.00005 -0.0025 354.00004 -0.0025 354.00005 -0.005 369.00004 -0.005 369.00005 0 370.00004 0 370.00005 0.01 385.00004 0.01 385.00005 0.005 400.00004 0.005 400.00005 0 415.00004 0 415.00005 -0.005 430.00004 -0.005 430.00005 -0.01 445.00004 -0.01 445.00005 0 446.00004 0 446.00005 0.005 461.00004 0.005 461.00005 0.0025 476.00004 0.0025 476.00005 0 491.00004 0 491.00005 -0.0025 506.00004 -0.0025 506.00005 -0.005 521.00004 -0.005 521.00005 0 582.00004 0 582.00005 -0.022 584.00004 -0.022 584.00005 0.022 586.00004 0.022 586.00005 0 588.1 0)
V_state_code state_code 0 PWL(0 1 6.00004 1 6.00005 2 66.00004 2 66.00005 3 141.00004 3 141.00005 9 142.00004 9 142.00005 4 217.00004 4 217.00005 9 218.00004 9 218.00005 5 293.00004 5 293.00005 9 294.00004 9 294.00005 6 369.00004 6 369.00005 9 370.00004 9 370.00005 7 445.00004 7 445.00005 9 446.00004 9 446.00005 8 521.00004 8 521.00005 9 522.00004 9 522.00005 10 582.00004 10 582.00005 11 588.00004 11 588.00005 0 588.1 0)
V_sample_select sample_select 0 PWL(0 0 6.00004 0 6.00005 1 582.00004 1 582.00005 0 588.00004 0 588.00005 1 588.1 1)
V_drive drive 0 PWL(0 1 6.00004 1 6.00005 0 66.00004 0 66.00005 1 522.00004 1 522.00005 0 582.00004 0 582.00005 1 588.00004 1 588.00005 0 588.1 0)
V_point_code point_code 0 PWL(0 0 1.00004 0 1.00005 1 2.00004 1 2.00005 2 3.00004 2 3.00005 3 4.00004 3 4.00005 4 5.00004 4 5.00005 5 6.00004 5 6.00005 0 81.00004 0 81.00005 1 96.00004 1 96.00005 2 111.00004 2 111.00005 3 126.00004 3 126.00005 4 141.00004 4 141.00005 0 157.00004 0 157.00005 1 172.00004 1 172.00005 2 187.00004 2 187.00005 3 202.00004 3 202.00005 4 217.00004 4 217.00005 0 233.00004 0 233.00005 1 248.00004 1 248.00005 2 263.00004 2 263.00005 3 278.00004 3 278.00005 4 293.00004 4 293.00005 0 309.00004 0 309.00005 1 324.00004 1 324.00005 2 339.00004 2 339.00005 3 354.00004 3 354.00005 4 369.00004 4 369.00005 0 385.00004 0 385.00005 1 400.00004 1 400.00005 2 415.00004 2 415.00005 3 430.00004 3 430.00005 4 445.00004 4 445.00005 0 461.00004 0 461.00005 1 476.00004 1 476.00005 2 491.00004 2 491.00005 3 506.00004 3 506.00005 4 521.00004 4 521.00005 0 583.00004 0 583.00005 1 584.00004 1 584.00005 2 585.00004 2 585.00005 3 586.00004 3 586.00005 4 587.00004 4 587.00005 5 588.00004 5 588.00005 0 588.1 0)
V_reverse reverse 0 PWL(0 0 294.00004 0 294.00005 1 369.00004 1 369.00005 0 370.00004 0 370.00005 1 445.00004 1 445.00005 0 446.00004 0 446.00005 1 521.00004 1 521.00005 0 588.1 0)
V_cal_role cal_role 0 PWL(0 1 4.00004 1 4.00005 2 6.00004 2 6.00005 0 582.00004 0 582.00005 1 586.00004 1 586.00005 2 588.00004 2 588.00005 0 588.1 0)
V_recovery_after recovery_after 0 PWL(0 0 141.00004 0 141.00005 3 142.00004 3 142.00005 0 217.00004 0 217.00005 4 218.00004 4 218.00005 0 293.00004 0 293.00005 5 294.00004 5 294.00005 0 369.00004 0 369.00005 6 370.00004 6 370.00005 0 445.00004 0 445.00005 7 446.00004 7 446.00005 0 521.00004 0 521.00005 8 522.00004 8 522.00005 0 588.1 0)
V_attempt attempt 0 PWL(0 0 588.1 0)
Vreset reset 0 0
Vcc vcc 0 5
Rmid_top vcc mid_raw 10k
Rmid_bottom mid_raw 0 10k
Cmid mid_raw 0 10u
Xmid mid_raw vmid vcc 0 vmid P1_OP
Btarget target 0 V=V(vmid)-V(req)
Xref re re_buf vcc 0 re_buf P1_OP
Xcontrol target re_buf vcc 0 drive_amp P1_OP
Sdrive drive_amp ce drive 0 SWITCH_PATH
.model SWITCH_PATH SW(Ron=1m Roff=1e15 Vt=.5 Vh=.05)
Rcounter ce re {RCOUNTER}
Vsense we metal 0
Ssample metal cellmetal sample_select 0 SWITCH_PATH
Bcal_select cal_select 0 V=1-V(sample_select)
Scal metal calmetal cal_select 0 SWITCH_PATH
Rcal calmetal re 10k
Rpolar cellmetal surf {RP}
Cdouble cellmetal surf {CDL}
Runcomp surf re {RU}
Xtia vmid we vcc 0 tia P1_OP
Rfeedback tia we {RF}
Cfeedback tia we 100p
Vnoise nunit 0 PWL FILE=noise.txt
Bcondition conditioned 0 V=V(vmid)+GAIN*if(V(reverse)>.5,REVERSEGAIN,1)*(V(tia)-V(vmid))+OFFSET+NOISE*V(nunit)+if(UNSTABLE>0,if(abs(V(state_code)-9)<.1,.1*sin(2*pi*time*2),0),0)
Rfilter conditioned adc 1k
Cfilter adc 0 1u
Radcload adc 0 1G
Bactual actual 0 V=V(we,re)
* Physical switch-capacitor track/hold models; no post-run time resampling.
Vclock clock 0 PULSE(0 1 .04989 10u 10u 100u .05)
.model SAMPLE_SWITCH SW(Ron=100 Roff=1e15 Vt=.5 Vh=0)
Sadc adc adc_hold clock 0 SAMPLE_SWITCH
Cadc_hold adc_hold 0 1n
Svoltage actual actual_hold clock 0 SAMPLE_SWITCH
Cvoltage_hold actual_hold 0 1n
Bmeas i_meas 0 V=(V(adc_hold)-V(vmid))/RF
* Instrument settings are circuit-generated telemetry, not inferred settings.
Vnom_gain nom_gain 0 1
Vadc_range adc_range 0 5
Vadc_rate adc_rate 0 20
* Truth channels saved only for the separate evaluator; adapter rejects them.
Btrue i_true 0 V=I(Vsense)
Binterface eta_truth 0 V=V(cellmetal,surf)
.options plotwinsize=0 reltol=1e-5 abstol=1p vntol=10n
.save V(clock) V(actual_hold) V(i_meas) V(req) V(drive) V(sample_select) V(state_code) V(point_code) V(reverse) V(cal_role) V(recovery_after) V(attempt) V(reset) V(adc_hold) V(vmid) V(nom_gain) V(adc_range) V(adc_rate) V(i_true) V(eta_truth) V(actual) V(ce)
.tran 0 588.1 0 25m
.end
