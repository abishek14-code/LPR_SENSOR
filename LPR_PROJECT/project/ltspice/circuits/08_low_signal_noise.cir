P1 08_low_signal_noise: 1mV excitation plus seeded 1mV RMS output-referred PWL noise
* Generated source case. Native LTspice execution has NOT occurred at delivery.
.param RU=10k RP=100k CDL=100u AMP=1m RF=1Meg RADC=1k CADC=1u GAINSTEP=0 OFFSET=0 NOISE=1m SWFAULT=0
.include ../models/electrical_core.inc
.end
