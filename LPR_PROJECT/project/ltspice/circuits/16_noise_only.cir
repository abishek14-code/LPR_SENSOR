P1 16_noise_only: Nominal excitation with 1mV RMS output-referred PWL noise
* Generated source case. Native LTspice execution has NOT occurred at delivery.
.param RU=10k RP=100k CDL=100u AMP=10m RF=1Meg RADC=1k CADC=1u GAINSTEP=0 OFFSET=0 NOISE=1m SWFAULT=0
.include ../models/electrical_core.inc
.end
