P1 5V supply, 2.5V divider and buffered midpoint load-step test
.include ../models/p1_opamp.lib
Vcc vcc 0 5
Rtop vcc mid_raw 10k
Rbottom mid_raw 0 10k
Cmid mid_raw 0 10u
Xmid mid_raw vmid vcc 0 vmid P1_OP
Iload vmid 0 PULSE(0 100u 0.1 1u 1u 0.1 1)
.tran 0 0.4 0 10u
.options plotwinsize=0
.save V(vmid) V(mid_raw)
.meas tran midpoint_loaded AVG V(vmid) FROM=0.15 TO=0.19
.meas tran midpoint_min MIN V(vmid)
.end
