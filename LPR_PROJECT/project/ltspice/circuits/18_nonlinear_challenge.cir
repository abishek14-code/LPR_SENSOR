P1 nonlinear symmetric Butler-Volmer challenge, ideal voltage excitation
* Total icorr in A; beta in V/decade. Not a fitted corrosion material model.
.param RU=10k RP=100k CDL=100u AMP=10m BETA=120m
.param ICORR={BETA/(2*ln(10)*RP)}
Vrequest req 0 PWL(0 0 1 0 1.000001 {AMP} 12 {AMP})
Ru req eta {RU}
Cdl eta 0 {CDL}
Bfaradaic eta 0 I=ICORR*(exp(ln(10)*V(eta)/BETA)-exp(-ln(10)*V(eta)/BETA))
Bactual actual 0 V=V(req)
Btrue i_true 0 V=(V(req)-V(eta))/RU
Bmeas i_meas 0 V=V(i_true)
Brelay relay 0 V=1
.step param AMP list 1m 10m 50m
.options plotwinsize=0 reltol=1e-6 abstol=1f
.tran 0 12 0 1m
.save V(req) V(actual) V(eta) V(i_true) V(i_meas) V(relay)
.meas tran i_steady AVG V(i_true) FROM=11 TO=12
.meas tran apparent_rdc PARAM AMP/i_steady
.end
