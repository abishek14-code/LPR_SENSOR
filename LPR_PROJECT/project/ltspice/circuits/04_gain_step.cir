P1 04_gain_step: 20 percent measurement gain increase at t=8s
* Generated source case. Native LTspice execution has NOT occurred at delivery.
.param RU=10k RP=100k CDL=100u AMP=10m RF=1Meg RADC=1k CADC=1u GAINSTEP=.2 OFFSET=0 NOISE=0 SWFAULT=0
.include ../models/electrical_core.inc
.end
