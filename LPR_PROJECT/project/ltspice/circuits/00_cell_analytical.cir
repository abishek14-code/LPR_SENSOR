P1 ideal Ru + (Rp || Cdl) analytical reference test
.param RU=10k RP=100k CDL=100u AMP=10m
Vrequest req 0 PWL(0 0 1 0 1.000001 {AMP} 12 {AMP})
Ru req eta {RU}
Rp eta 0 {RP}
Cdl eta 0 {CDL}
Bactual actual 0 V=V(req)
Bcurrent i_true 0 V=(V(req)-V(eta))/RU
Bmeasured i_meas 0 V=V(i_true)
Brelay relay 0 V=1
.options plotwinsize=0 reltol=1e-6 abstol=1f vntol=1n
.tran 0 12 0 1m
.save V(req) V(actual) V(eta) V(i_true) V(i_meas) V(relay)
.meas tran i_initial FIND V(i_true) AT=1.000001
.meas tran i_steady AVG V(i_true) FROM=11 TO=12
.meas tran tau_observed WHEN V(i_true)={AMP/(RU+RP)+(AMP/RU-AMP/(RU+RP))/exp(1)} FALL=1
.meas tran tau_corrected PARAM tau_observed-1.000001
.meas tran rdc PARAM AMP/i_steady
.end
