P1 05_offset_step: 5mV output-referred offset at t=8s
* Generated source case. Native LTspice execution has NOT occurred at delivery.
.param RU=10k RP=100k CDL=100u AMP=10m RF=1Meg RADC=1k CADC=1u GAINSTEP=0 OFFSET=5m NOISE=0 SWFAULT=0
.include ../models/electrical_core.inc
.end
