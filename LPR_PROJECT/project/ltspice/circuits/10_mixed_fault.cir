P1 10_mixed_fault: Gain, offset, slow cell and output noise combined
* Generated source case. Native LTspice execution has NOT occurred at delivery.
.param RU=10k RP=100k CDL=1m AMP=10m RF=1Meg RADC=1k CADC=1u GAINSTEP=.2 OFFSET=5m NOISE=1m SWFAULT=0
.include ../models/electrical_core.inc
.end
