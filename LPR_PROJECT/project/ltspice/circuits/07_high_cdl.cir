P1 07_high_cdl: Slow cell Cdl=1mF, nominal tau=9.09s
* Generated source case. Native LTspice execution has NOT occurred at delivery.
.param RU=10k RP=100k CDL=1m AMP=10m RF=1Meg RADC=1k CADC=1u GAINSTEP=0 OFFSET=0 NOISE=0 SWFAULT=0
.include ../models/electrical_core.inc
.end
